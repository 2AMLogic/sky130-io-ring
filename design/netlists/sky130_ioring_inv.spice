** sch_path: /home/ubuntu/GitHub/sky130-io-ring/.loom/worktrees/issue-30/design/xschem/sky130_ioring_inv.sch
.subckt sky130_ioring_inv A Y VDD VSS
*.PININFO A:I Y:O VDD:B VSS:B
XMP Y A VDD VDD sky130_fd_pr__pfet_01v8 L=0.15 W=1.0 nf=1 ad=0.29 as=0.29 pd=2.58 ps=2.58 nrd=0.29 nrs=0.29 sa=0 sb=0 sd=0 mult=1
+ m=1
XMN Y A VSS VSS sky130_fd_pr__nfet_01v8 L=0.15 W=0.65 nf=1 ad=0.1885 as=0.1885 pd=1.88 ps=1.88 nrd=0.446153846153846
+ nrs=0.446153846153846 sa=0 sb=0 sd=0 mult=1 m=1
.ends
