** klt-netlist-inputs: {"pdk_variant": "sky130A", "rcfile": "xschemrc", "xschem_version": "3.4.7"}
** sch_path: design/xschem/sky130_ioring_vss.sch
.subckt sky130_ioring_vss VDDIO VDD VSS
*.PININFO VDDIO:B VDD:B VSS:B
.ends
