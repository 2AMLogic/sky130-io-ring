** klt-netlist-inputs: {"pdk_variant": "sky130A", "rcfile": "xschemrc", "xschem_version": "3.4.7"}
** sch_path: design/xschem/sky130_ioring_gpio_pulls.sch
.subckt sky130_ioring_gpio_pulls PUN PDP PAD VDDIO VSS
*.PININFO PUN:I PDP:I PAD:B VDDIO:B VSS:B
XMPU PAD PUN VDDIO VDDIO sky130_fd_pr__pfet_g5v0d10v5 L=4 W=2.5 nf=1 ad=0.725 as=0.725 pd=5.58 ps=5.58 nrd=0.116 nrs=0.116 sa=0
+ sb=0 sd=0 mult=1 m=1
XMPD PAD PDP VSS VSS sky130_fd_pr__nfet_g5v0d10v5 L=4 W=1 nf=1 ad=0.29 as=0.29 pd=2.58 ps=2.58 nrd=0.29 nrs=0.29 sa=0 sb=0 sd=0
+ mult=1 m=1
.ends
