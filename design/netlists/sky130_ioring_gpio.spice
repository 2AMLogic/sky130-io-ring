** sch_path: /home/ubuntu/GitHub/sky130-io-ring/.loom/worktrees/issue-30/design/xschem/sky130_ioring_gpio.sch
.subckt sky130_ioring_gpio A OE IE PU PD Y PAD VDDIO VDD VSS
*.PININFO A:I OE:I IE:I PU:I PD:I Y:O PAD:B VDDIO:B VDD:B VSS:B
X1 A OE PU PD PG_C NG_C PUN_C PD_C VDD VSS sky130_ioring_gpio_logic
XL1 PG_C PG VDD VDDIO VSS sky130_ioring_gpio_ls
XL2 NG_C NG VDD VDDIO VSS sky130_ioring_gpio_ls
XL3 PUN_C PUN VDD VDDIO VSS sky130_ioring_gpio_ls
XL4 PD_C PDP VDD VDDIO VSS sky130_ioring_gpio_ls
X2 PG NG PAD VDDIO VSS sky130_ioring_gpio_drv
X3 PUN PDP PAD VDDIO VSS sky130_ioring_gpio_pulls
X4 PAD RXG VDDIO VSS sky130_ioring_gpio_esd
X5 RXG IE Y VDD VDDIO VSS sky130_ioring_gpio_rcv
.ends

* expanding   symbol:  sky130_ioring_gpio_logic.sym # of pins=10
** sym_path: /home/ubuntu/GitHub/sky130-io-ring/.loom/worktrees/issue-30/design/xschem/sky130_ioring_gpio_logic.sym
** sch_path: /home/ubuntu/GitHub/sky130-io-ring/.loom/worktrees/issue-30/design/xschem/sky130_ioring_gpio_logic.sch
.subckt sky130_ioring_gpio_logic A OE PU PD PG_C NG_C PUN_C PD_C VDD VSS
*.PININFO A:I OE:I PU:I PD:I PG_C:O NG_C:O PUN_C:O PD_C:O VDD:B VSS:B
X1 OE OEB VDD VSS sky130_ioring_inv
X2 PU PUB VDD VSS sky130_ioring_inv
X3 PD PDB VDD VSS sky130_ioring_inv
X4 A OE PG_C VDD VSS sky130_ioring_nand2
X5 A OEB NG_C VDD VSS sky130_ioring_nor2
X6 PU PDB OEB PUN_C VDD VSS sky130_ioring_nand3
X7 PD PUB OEB PDN VDD VSS sky130_ioring_nand3
X8 PDN PD_C VDD VSS sky130_ioring_inv
.ends

* expanding   symbol:  sky130_ioring_gpio_ls.sym # of pins=5
** sym_path: /home/ubuntu/GitHub/sky130-io-ring/.loom/worktrees/issue-30/design/xschem/sky130_ioring_gpio_ls.sym
** sch_path: /home/ubuntu/GitHub/sky130-io-ring/.loom/worktrees/issue-30/design/xschem/sky130_ioring_gpio_ls.sch
.subckt sky130_ioring_gpio_ls IN OUT VDD VDDIO VSS
*.PININFO IN:I OUT:O VDD:B VDDIO:B VSS:B
X1 IN INB VDD VSS sky130_ioring_inv
XMNA OUTB IN VSS VSS sky130_fd_pr__nfet_g5v0d10v5 L=0.5 W=2 nf=1 ad=0.58 as=0.58 pd=4.58 ps=4.58 nrd=0.145 nrs=0.145 sa=0 sb=0
+ sd=0 mult=2 m=2
XMNB OUT INB VSS VSS sky130_fd_pr__nfet_g5v0d10v5 L=0.5 W=2 nf=1 ad=0.58 as=0.58 pd=4.58 ps=4.58 nrd=0.145 nrs=0.145 sa=0 sb=0
+ sd=0 mult=2 m=2
XMPA OUTB OUT VDDIO VDDIO sky130_fd_pr__pfet_g5v0d10v5 L=0.5 W=0.5 nf=1 ad=0.145 as=0.145 pd=1.58 ps=1.58 nrd=0.58 nrs=0.58 sa=0
+ sb=0 sd=0 mult=1 m=1
XMPB OUT OUTB VDDIO VDDIO sky130_fd_pr__pfet_g5v0d10v5 L=0.5 W=0.5 nf=1 ad=0.145 as=0.145 pd=1.58 ps=1.58 nrd=0.58 nrs=0.58 sa=0
+ sb=0 sd=0 mult=1 m=1
.ends

* expanding   symbol:  sky130_ioring_gpio_drv.sym # of pins=5
** sym_path: /home/ubuntu/GitHub/sky130-io-ring/.loom/worktrees/issue-30/design/xschem/sky130_ioring_gpio_drv.sym
** sch_path: /home/ubuntu/GitHub/sky130-io-ring/.loom/worktrees/issue-30/design/xschem/sky130_ioring_gpio_drv.sch
.subckt sky130_ioring_gpio_drv PG NG PAD VDDIO VSS
*.PININFO PG:I NG:I PAD:B VDDIO:B VSS:B
XMP PAD PG VDDIO VDDIO sky130_fd_pr__pfet_g5v0d10v5 L=0.5 W=5 nf=1 ad=1.45 as=1.45 pd=10.58 ps=10.58 nrd=0.058 nrs=0.058 sa=0 sb=0
+ sd=0 mult=20 m=20
XMN PAD NG VSS VSS sky130_fd_pr__nfet_g5v0d10v5 L=0.5 W=5 nf=1 ad=1.45 as=1.45 pd=10.58 ps=10.58 nrd=0.058 nrs=0.058 sa=0 sb=0
+ sd=0 mult=10 m=10
.ends

* expanding   symbol:  sky130_ioring_gpio_pulls.sym # of pins=5
** sym_path: /home/ubuntu/GitHub/sky130-io-ring/.loom/worktrees/issue-30/design/xschem/sky130_ioring_gpio_pulls.sym
** sch_path: /home/ubuntu/GitHub/sky130-io-ring/.loom/worktrees/issue-30/design/xschem/sky130_ioring_gpio_pulls.sch
.subckt sky130_ioring_gpio_pulls PUN PDP PAD VDDIO VSS
*.PININFO PUN:I PDP:I PAD:B VDDIO:B VSS:B
XMPU PAD PUN VDDIO VDDIO sky130_fd_pr__pfet_g5v0d10v5 L=4 W=1 nf=1 ad=0.29 as=0.29 pd=2.58 ps=2.58 nrd=0.29 nrs=0.29 sa=0 sb=0
+ sd=0 mult=1 m=1
XMPD PAD PDP VSS VSS sky130_fd_pr__nfet_g5v0d10v5 L=4 W=1 nf=1 ad=0.29 as=0.29 pd=2.58 ps=2.58 nrd=0.29 nrs=0.29 sa=0 sb=0 sd=0
+ mult=1 m=1
.ends

* expanding   symbol:  sky130_ioring_gpio_esd.sym # of pins=4
** sym_path: /home/ubuntu/GitHub/sky130-io-ring/.loom/worktrees/issue-30/design/xschem/sky130_ioring_gpio_esd.sym
** sch_path: /home/ubuntu/GitHub/sky130-io-ring/.loom/worktrees/issue-30/design/xschem/sky130_ioring_gpio_esd.sch
.subckt sky130_ioring_gpio_esd PAD RXG VDDIO VSS
*.PININFO PAD:B RXG:O VDDIO:B VSS:B
XDP PAD VDDIO sky130_fd_pr__diode_pd2nw_05v5 area=2e14 perim=6e7
XDN VSS PAD sky130_fd_pr__diode_pw2nd_05v5 area=2e14 perim=6e7
XRS RXG PAD VSS sky130_fd_pr__res_high_po_1p41 L=1.0 mult=1 m=1
XDLP RXG VDDIO sky130_fd_pr__diode_pd2nw_05v5 area=1e13 perim=1.4e7
XDLN VSS RXG sky130_fd_pr__diode_pw2nd_05v5 area=1e13 perim=1.4e7
.ends

* expanding   symbol:  sky130_ioring_gpio_rcv.sym # of pins=6
** sym_path: /home/ubuntu/GitHub/sky130-io-ring/.loom/worktrees/issue-30/design/xschem/sky130_ioring_gpio_rcv.sym
** sch_path: /home/ubuntu/GitHub/sky130-io-ring/.loom/worktrees/issue-30/design/xschem/sky130_ioring_gpio_rcv.sch
.subckt sky130_ioring_gpio_rcv RXG IE Y VDD VDDIO VSS
*.PININFO RXG:I IE:I Y:O VDD:B VDDIO:B VSS:B
XMP1 p1 RXG VDDIO VDDIO sky130_fd_pr__pfet_g5v0d10v5 L=0.5 W=2 nf=1 ad=0.58 as=0.58 pd=4.58 ps=4.58 nrd=0.145 nrs=0.145 sa=0 sb=0
+ sd=0 mult=1 m=1
XMP2 SCHN RXG p1 VDDIO sky130_fd_pr__pfet_g5v0d10v5 L=0.5 W=2 nf=1 ad=0.58 as=0.58 pd=4.58 ps=4.58 nrd=0.145 nrs=0.145 sa=0 sb=0
+ sd=0 mult=1 m=1
XMN1 SCHN RXG n1 VSS sky130_fd_pr__nfet_g5v0d10v5 L=0.5 W=1 nf=1 ad=0.29 as=0.29 pd=2.58 ps=2.58 nrd=0.29 nrs=0.29 sa=0 sb=0 sd=0
+ mult=1 m=1
XMN2 n1 RXG VSS VSS sky130_fd_pr__nfet_g5v0d10v5 L=0.5 W=1 nf=1 ad=0.29 as=0.29 pd=2.58 ps=2.58 nrd=0.29 nrs=0.29 sa=0 sb=0 sd=0
+ mult=1 m=1
XMN3 VDDIO SCHN n1 VSS sky130_fd_pr__nfet_g5v0d10v5 L=0.5 W=0.5 nf=1 ad=0.145 as=0.145 pd=1.58 ps=1.58 nrd=0.58 nrs=0.58 sa=0 sb=0
+ sd=0 mult=1 m=1
XMP3 VSS SCHN p1 VDDIO sky130_fd_pr__pfet_g5v0d10v5 L=0.5 W=0.5 nf=1 ad=0.145 as=0.145 pd=1.58 ps=1.58 nrd=0.58 nrs=0.58 sa=0 sb=0
+ sd=0 mult=1 m=1
XMP4 RXL SCHN VDD VDD sky130_fd_pr__pfet_g5v0d10v5 L=0.5 W=1 nf=1 ad=0.29 as=0.29 pd=2.58 ps=2.58 nrd=0.29 nrs=0.29 sa=0 sb=0 sd=0
+ mult=1 m=1
XMN4 RXL SCHN VSS VSS sky130_fd_pr__nfet_g5v0d10v5 L=0.5 W=0.5 nf=1 ad=0.145 as=0.145 pd=1.58 ps=1.58 nrd=0.58 nrs=0.58 sa=0 sb=0
+ sd=0 mult=1 m=1
X1 RXL IE RXN VDD VSS sky130_ioring_nand2
X2 RXN Y VDD VSS sky130_ioring_inv
.ends

* expanding   symbol:  sky130_ioring_inv.sym # of pins=4
** sym_path: /home/ubuntu/GitHub/sky130-io-ring/.loom/worktrees/issue-30/design/xschem/sky130_ioring_inv.sym
** sch_path: /home/ubuntu/GitHub/sky130-io-ring/.loom/worktrees/issue-30/design/xschem/sky130_ioring_inv.sch
.subckt sky130_ioring_inv A Y VDD VSS
*.PININFO A:I Y:O VDD:B VSS:B
XMP Y A VDD VDD sky130_fd_pr__pfet_01v8 L=0.15 W=1.0 nf=1 ad=0.29 as=0.29 pd=2.58 ps=2.58 nrd=0.29 nrs=0.29 sa=0 sb=0 sd=0 mult=1
+ m=1
XMN Y A VSS VSS sky130_fd_pr__nfet_01v8 L=0.15 W=0.65 nf=1 ad=0.1885 as=0.1885 pd=1.88 ps=1.88 nrd=0.446153846153846
+ nrs=0.446153846153846 sa=0 sb=0 sd=0 mult=1 m=1
.ends

* expanding   symbol:  sky130_ioring_nand2.sym # of pins=5
** sym_path: /home/ubuntu/GitHub/sky130-io-ring/.loom/worktrees/issue-30/design/xschem/sky130_ioring_nand2.sym
** sch_path: /home/ubuntu/GitHub/sky130-io-ring/.loom/worktrees/issue-30/design/xschem/sky130_ioring_nand2.sch
.subckt sky130_ioring_nand2 A B Y VDD VSS
*.PININFO A:I B:I Y:O VDD:B VSS:B
XMPA Y A VDD VDD sky130_fd_pr__pfet_01v8 L=0.15 W=1.0 nf=1 ad=0.29 as=0.29 pd=2.58 ps=2.58 nrd=0.29 nrs=0.29 sa=0 sb=0 sd=0 mult=1
+ m=1
XMPB Y B VDD VDD sky130_fd_pr__pfet_01v8 L=0.15 W=1.0 nf=1 ad=0.29 as=0.29 pd=2.58 ps=2.58 nrd=0.29 nrs=0.29 sa=0 sb=0 sd=0 mult=1
+ m=1
XMNA Y A n1 VSS sky130_fd_pr__nfet_01v8 L=0.15 W=1.0 nf=1 ad=0.29 as=0.29 pd=2.58 ps=2.58 nrd=0.29 nrs=0.29 sa=0 sb=0 sd=0 mult=1
+ m=1
XMNB n1 B VSS VSS sky130_fd_pr__nfet_01v8 L=0.15 W=1.0 nf=1 ad=0.29 as=0.29 pd=2.58 ps=2.58 nrd=0.29 nrs=0.29 sa=0 sb=0 sd=0
+ mult=1 m=1
.ends

* expanding   symbol:  sky130_ioring_nor2.sym # of pins=5
** sym_path: /home/ubuntu/GitHub/sky130-io-ring/.loom/worktrees/issue-30/design/xschem/sky130_ioring_nor2.sym
** sch_path: /home/ubuntu/GitHub/sky130-io-ring/.loom/worktrees/issue-30/design/xschem/sky130_ioring_nor2.sch
.subckt sky130_ioring_nor2 A B Y VDD VSS
*.PININFO A:I B:I Y:O VDD:B VSS:B
XMPA p1 A VDD VDD sky130_fd_pr__pfet_01v8 L=0.15 W=2.0 nf=1 ad=0.58 as=0.58 pd=4.58 ps=4.58 nrd=0.145 nrs=0.145 sa=0 sb=0 sd=0
+ mult=1 m=1
XMPB Y B p1 VDD sky130_fd_pr__pfet_01v8 L=0.15 W=2.0 nf=1 ad=0.58 as=0.58 pd=4.58 ps=4.58 nrd=0.145 nrs=0.145 sa=0 sb=0 sd=0
+ mult=1 m=1
XMNA Y A VSS VSS sky130_fd_pr__nfet_01v8 L=0.15 W=0.65 nf=1 ad=0.1885 as=0.1885 pd=1.88 ps=1.88 nrd=0.446153846153846
+ nrs=0.446153846153846 sa=0 sb=0 sd=0 mult=1 m=1
XMNB Y B VSS VSS sky130_fd_pr__nfet_01v8 L=0.15 W=0.65 nf=1 ad=0.1885 as=0.1885 pd=1.88 ps=1.88 nrd=0.446153846153846
+ nrs=0.446153846153846 sa=0 sb=0 sd=0 mult=1 m=1
.ends

* expanding   symbol:  sky130_ioring_nand3.sym # of pins=6
** sym_path: /home/ubuntu/GitHub/sky130-io-ring/.loom/worktrees/issue-30/design/xschem/sky130_ioring_nand3.sym
** sch_path: /home/ubuntu/GitHub/sky130-io-ring/.loom/worktrees/issue-30/design/xschem/sky130_ioring_nand3.sch
.subckt sky130_ioring_nand3 A B C Y VDD VSS
*.PININFO A:I B:I C:I Y:O VDD:B VSS:B
XMPA Y A VDD VDD sky130_fd_pr__pfet_01v8 L=0.15 W=1.0 nf=1 ad=0.29 as=0.29 pd=2.58 ps=2.58 nrd=0.29 nrs=0.29 sa=0 sb=0 sd=0 mult=1
+ m=1
XMPB Y B VDD VDD sky130_fd_pr__pfet_01v8 L=0.15 W=1.0 nf=1 ad=0.29 as=0.29 pd=2.58 ps=2.58 nrd=0.29 nrs=0.29 sa=0 sb=0 sd=0 mult=1
+ m=1
XMPC Y C VDD VDD sky130_fd_pr__pfet_01v8 L=0.15 W=1.0 nf=1 ad=0.29 as=0.29 pd=2.58 ps=2.58 nrd=0.29 nrs=0.29 sa=0 sb=0 sd=0 mult=1
+ m=1
XMNA Y A n1 VSS sky130_fd_pr__nfet_01v8 L=0.15 W=1.5 nf=1 ad=0.435 as=0.435 pd=3.58 ps=3.58 nrd=0.193333333333333
+ nrs=0.193333333333333 sa=0 sb=0 sd=0 mult=1 m=1
XMNB n1 B n2 VSS sky130_fd_pr__nfet_01v8 L=0.15 W=1.5 nf=1 ad=0.435 as=0.435 pd=3.58 ps=3.58 nrd=0.193333333333333
+ nrs=0.193333333333333 sa=0 sb=0 sd=0 mult=1 m=1
XMNC n2 C VSS VSS sky130_fd_pr__nfet_01v8 L=0.15 W=1.5 nf=1 ad=0.435 as=0.435 pd=3.58 ps=3.58 nrd=0.193333333333333
+ nrs=0.193333333333333 sa=0 sb=0 sd=0 mult=1 m=1
.ends
