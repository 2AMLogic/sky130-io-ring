** klt-netlist-inputs: {"pdk_variant": "sky130A", "rcfile": "xschemrc", "xschem_version": "3.4.7"}
** sch_path: design/xschem/sky130_ioring_gpio_drv.sch
.subckt sky130_ioring_gpio_drv PG NG PAD VDDIO VSS
*.PININFO PG:I NG:I PAD:B VDDIO:B VSS:B
XMP PAD PG VDDIO VDDIO sky130_fd_pr__pfet_g5v0d10v5 L=0.5 W=5 nf=1 ad=1.45 as=1.45 pd=10.58 ps=10.58 nrd=0.058 nrs=0.058 sa=0 sb=0
+ sd=0 mult=20 m=20
XMN PAD NG VSS VSS sky130_fd_pr__nfet_g5v0d10v5 L=0.5 W=5 nf=1 ad=1.45 as=1.45 pd=10.58 ps=10.58 nrd=0.058 nrs=0.058 sa=0 sb=0
+ sd=0 mult=10 m=10
.ends
