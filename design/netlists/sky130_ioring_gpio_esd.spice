** sch_path: /home/ubuntu/GitHub/sky130-io-ring/.loom/worktrees/issue-30/design/xschem/sky130_ioring_gpio_esd.sch
.subckt sky130_ioring_gpio_esd PAD RXG VDDIO VSS
*.PININFO PAD:B RXG:O VDDIO:B VSS:B
XDP PAD VDDIO sky130_fd_pr__diode_pd2nw_05v5 area=2e14 perim=6e7
XDN VSS PAD sky130_fd_pr__diode_pw2nd_05v5 area=2e14 perim=6e7
XRS RXG PAD VSS sky130_fd_pr__res_high_po_1p41 L=1.0 mult=1 m=1
XDLP RXG VDDIO sky130_fd_pr__diode_pd2nw_05v5 area=1e13 perim=1.4e7
XDLN VSS RXG sky130_fd_pr__diode_pw2nd_05v5 area=1e13 perim=1.4e7
.ends
