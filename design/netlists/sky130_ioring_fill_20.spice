** sch_path: /home/ubuntu/GitHub/sky130-io-ring/.loom/worktrees/issue-30/design/xschem/sky130_ioring_fill_20.sch
.subckt sky130_ioring_fill_20 VDDIO VDD VSS
*.PININFO VDDIO:B VDD:B VSS:B
.ends
