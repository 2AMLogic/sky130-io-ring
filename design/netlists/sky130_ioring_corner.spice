** sch_path: /home/ubuntu/GitHub/sky130-io-ring/.loom/worktrees/issue-30/design/xschem/sky130_ioring_corner.sch
.subckt sky130_ioring_corner VDDIO VDD VSS
*.PININFO VDDIO:B VDD:B VSS:B
.ends
